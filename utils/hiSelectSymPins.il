procedure(hiSelectSymPins(  )
    hiRegTimer("hiFormDone(schSymSelectPropForm)" 8)
    hiRegTimer("hiiSetCurrentForm('schSymSelectPropForm)" 5)
schHiSelectByProperty("select")
)
